** Profile: "SCHEMATIC1-Originall_values"  [ d:\orcad projects\digital_logic_probe_v5\digital_logic_probe_v5-PSpiceFiles\SCHEMATIC1\Originall_values.sim ]

** Creating circuit file "Originall_values.cir"
** WARNING: THIS AUTOMATICALLY GENERATED FILE MAY BE OVERWRITTEN BY SUBSEQUENT SIMULATIONS

*Libraries:
* Profile Libraries :
* Local Libraries :
* From [PSPICE NETLIST] section of C:\Users\sixsi\AppData\Roaming\SPB_Data\cdssetup\OrCAD_PSpice\17.4.0\PSpice.ini file:
.lib "nom.lib"

*Analysis directives:
.DC LIN V_Vin 0 5.44 1m
.OPTIONS ADVCONV
.PROBE64 V(alias(*)) I(alias(*)) W(alias(*)) D(alias(*)) NOISE(alias(*))
.INC "..\SCHEMATIC1.net"

.END
